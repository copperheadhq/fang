* time_delay: dc_gain
* plan for ngspice over sha256:d5c7b5aa80e63f0d97709420a2678b7fdf020a29ab643c9c09dde304196bcf52
C1 1 2 8n
C2 2 3 8n
C3 4 0 36n
C4 6 0 36n
* GND1 abstracted; no device emitted
R1 1 3 60k
R2 7 4 10k
R3 4 6 40k
R4 6 1 10k
R5 2 0 15k
* TP1 abstracted; no device emitted
* TP2 abstracted; no device emitted
* U1 abstracted; no device emitted
.options abstol=1e-12
.options method=gear
.options reltol=1e-3
.options vntol=1e-6
.op
* added by the bench: the drive, and the parts fang abstracted
VDRIVE_e_in 7 0 DC 1
XU1 0 1 3 HB_OPAMP A=1e+06 GBW=1e+07 VOH=13.5 VOL=-13.5 VOS=0
.subckt HB_OPAMP inp inn out A=1e6 GBW=1e7 VOH=13.5 VOL=-13.5 VOS=0
VOS inp x DC {VOS}
RIN x inn 1e12
GM 0 n1 x inn 1e-3
R1 n1 0 {A*1e3}
C1 n1 0 {1e-3/(6.283185307179586*GBW)}
DH n1 h HB_CLAMP
VH h 0 DC {VOH}
DL l n1 HB_CLAMP
VL l 0 DC {VOL}
EO out 0 n1 0 1
.model HB_CLAMP D(IS=1e-15 N=0.01)
.ends HB_OPAMP
.control
run
let gain = v(3) / v(7)
print gain
.endc
.end
