* lag_element: corner
* plan for ngspice over sha256:1e305e9f1f71d6aae4efbfc40152d3b276eb47dadd0e0aa16521fcaa04e8181d
C1 1 2 10u
* GND1 abstracted; no device emitted
R1 4 1 1Meg
R2 1 2 10k
* TP1 abstracted; no device emitted
* TP2 abstracted; no device emitted
* U1 abstracted; no device emitted
.options abstol=1e-12
.options method=gear
.options reltol=1e-3
.options vntol=1e-6
.ac dec 200 10m 1k
* added by the bench: the drive, and the parts fang abstracted
VDRIVE_e_in 4 0 DC 0 AC 1
XU1 0 1 2 HB_OPAMP A=1e+06 GBW=1e+07 VOH=13.5 VOL=-13.5 VOS=0
.subckt HB_OPAMP inp inn out A=1e6 GBW=1e7 VOH=13.5 VOL=-13.5 VOS=0
VOS inp x DC {VOS}
RIN x inn 1e12
GM 0 n1 x inn 1e-3
R1 n1 0 {A*1e3}
C1 n1 0 {1e-3/(6.283185307179586*GBW)}
DH n1 h HB_CLAMP
VH h 0 DC {VOH}
DL l n1 HB_CLAMP
VL l 0 DC {VOL}
EO out 0 n1 0 1
.model HB_CLAMP D(IS=1e-15 N=0.01)
.ends HB_OPAMP
.control
run
meas ac gain_low find vm(2) at=10m
meas ac f_3db when vdb(2)=-43.0103 fall=1
.endc
.end
