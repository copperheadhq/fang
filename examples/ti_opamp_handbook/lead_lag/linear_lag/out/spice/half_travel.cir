* linear_lag: half_travel
* plan for ngspice over sha256:728046891ba220bceecfc254ec7550752dfb0db90979cb3bed184e0590cde745
C1 1 0 10u
* GND1 abstracted; no device emitted
* RV1 abstracted; no device emitted
* TP1 abstracted; no device emitted
* TP2 abstracted; no device emitted
* U1 abstracted; no device emitted
.options abstol=1e-12
.options method=gear
.options reltol=1e-3
.options vntol=1e-6
.ac dec 200 10m 1k
* added by the bench: the drive, and the parts fang abstracted
VDRIVE_e_in 3 0 DC 0 AC 1
RRV1_A 1 3 5000
RRV1_B 3 3 5000
XU1 1 4 4 HB_OPAMP A=1e+06 GBW=1e+07 VOH=13.5 VOL=-13.5 VOS=0
.subckt HB_OPAMP inp inn out A=1e6 GBW=1e7 VOH=13.5 VOL=-13.5 VOS=0
VOS inp x DC {VOS}
RIN x inn 1e12
GM 0 n1 x inn 1e-3
R1 n1 0 {A*1e3}
C1 n1 0 {1e-3/(6.283185307179586*GBW)}
DH n1 h HB_CLAMP
VH h 0 DC {VOH}
DL l n1 HB_CLAMP
VL l 0 DC {VOL}
EO out 0 n1 0 1
.model HB_CLAMP D(IS=1e-15 N=0.01)
.ends HB_OPAMP
.control
run
meas ac f_3db when vdb(4)=-3.0103 fall=1
.endc
.end
