* lead_lag: response
* plan for ngspice over sha256:ad83dbfed154341ca78b95be095d947be0694f5a54aff482de2fc066bdb69e7c
C1 1 0 10u
C2 3 0 10u
* GND1 abstracted; no device emitted
* RV1 abstracted; no device emitted
* RV2 abstracted; no device emitted
* TP1 abstracted; no device emitted
* TP2 abstracted; no device emitted
* U1 abstracted; no device emitted
.options abstol=1e-12
.options method=gear
.options reltol=1e-3
.options vntol=1e-6
.ac dec 200 100m 1k
* added by the bench: the drive, and the parts fang abstracted
VDRIVE_e_in 6 0 DC 0 AC 1
RRV1_A 4 1 5000
RRV1_B 1 5 5000
RRV2_A 6 3 1000
RRV2_B 3 4 9000
XU1 0 4 5 HB_OPAMP A=1e+06 GBW=1e+07 VOH=13.5 VOL=-13.5 VOS=0
.subckt HB_OPAMP inp inn out A=1e6 GBW=1e7 VOH=13.5 VOL=-13.5 VOS=0
VOS inp x DC {VOS}
RIN x inn 1e12
GM 0 n1 x inn 1e-3
R1 n1 0 {A*1e3}
C1 n1 0 {1e-3/(6.283185307179586*GBW)}
DH n1 h HB_CLAMP
VH h 0 DC {VOH}
DL l n1 HB_CLAMP
VL l 0 DC {VOL}
EO out 0 n1 0 1
.model HB_CLAMP D(IS=1e-15 N=0.01)
.ends HB_OPAMP
.control
run
meas ac gain_low find vm(5) at=100m
meas ac gain_100 find vm(5) at=100
meas ac phase_peak find vp(5) at=10.61
.endc
.end
