* wien_bridge_oscillator: regulating_6khz
* plan for ngspice over sha256:34021c9a900b0e3dccb209c0cb459b7a2a15b1985fb5a8a2dfd74a6cddc93717
C1 1 2 15.9n
C2 2 0 15.9n
* GND1 abstracted; no device emitted
* LP1 abstracted; no device emitted
R1 5 6 1.8k
R2 6 4 220
* RV1 abstracted; no device emitted
* RV2 abstracted; no device emitted
* RV3 abstracted; no device emitted
* TP1 abstracted; no device emitted
* U1 abstracted; no device emitted
.options abstol=1e-12
.options method=gear
.options reltol=1e-3
.options vntol=1e-6
.tran 1u 1
* added by the bench: the drive, and the parts fang abstracted
BLP1 4 0 I = V(4,0) / (70 + 4602.04 * V(th_LP1))
BLP1_HEAT 0 th_LP1 I = V(4,0) * V(4,0) / (70 + 4602.04 * V(th_LP1))
RLP1_TH th_LP1 0 1
CLP1_TH th_LP1 0 0.05
RRV1_A 7 7 450
RRV1_B 7 5 50
RRV2_A 7 1 1666.67
RRV2_B 1 1 98333.3
RRV3_A 2 0 1666.67
RRV3_B 0 0 98333.3
XU1 2 6 7 HB_OPAMP A=1e+06 GBW=1e+07 VOH=60 VOL=-60 VOS=0
.ic v(1)=0.1
.subckt HB_OPAMP inp inn out A=1e6 GBW=1e7 VOH=13.5 VOL=-13.5 VOS=0
VOS inp x DC {VOS}
RIN x inn 1e12
GM 0 n1 x inn 1e-3
R1 n1 0 {A*1e3}
C1 n1 0 {1e-3/(6.283185307179586*GBW)}
DH n1 h HB_CLAMP
VH h 0 DC {VOH}
DL l n1 HB_CLAMP
VL l 0 DC {VOL}
EO out 0 n1 0 1
.model HB_CLAMP D(IS=1e-15 N=0.01)
.ends HB_OPAMP
.control
run
meas tran t_first when v(7)=0 rise=1 td=0.95
meas tran t_last when v(7)=0 rise=21 td=0.95
let f_o = 20 / (t_last - t_first)
print f_o
meas tran peak_late max v(7) from=0.75 to=0.8
meas tran peak_end max v(7) from=0.95 to=1
let settled = peak_end / peak_late
print settled
meas tran lamp_rms rms v(4) from=0.95 to=1
meas tran summing_rms rms v(6) from=0.95 to=1
let lamp_resistance = 220 * lamp_rms / (summing_rms - lamp_rms)
print lamp_resistance
.endc
.end
