* simple_oscillator: oscillation
* plan for ngspice over sha256:74bb0b9883944fdc28a6f5c5fc1dcb9700858563a981400a16ec047350be02ed
C1 1 2 15.9n
C2 2 3 15.9n
C3 4 0 31.8n
* GND1 abstracted; no device emitted
R1 1 4 10k
R2 4 3 10k
* RV1 abstracted; no device emitted
* TP1 abstracted; no device emitted
* U1 abstracted; no device emitted
.options abstol=1e-12
.options method=gear
.options reltol=1e-3
.options vntol=1e-6
.tran 2u 200m
* added by the bench: the drive, and the parts fang abstracted
RRV1_A 2 0 4900
RRV1_B 0 0 5100
XU1 0 3 1 HB_OPAMP A=1e+06 GBW=1e+07 VOH=13.5 VOL=-13.5 VOS=0
.ic v(4)=1
.subckt HB_OPAMP inp inn out A=1e6 GBW=1e7 VOH=13.5 VOL=-13.5 VOS=0
VOS inp x DC {VOS}
RIN x inn 1e12
GM 0 n1 x inn 1e-3
R1 n1 0 {A*1e3}
C1 n1 0 {1e-3/(6.283185307179586*GBW)}
DH n1 h HB_CLAMP
VH h 0 DC {VOH}
DL l n1 HB_CLAMP
VL l 0 DC {VOL}
EO out 0 n1 0 1
.model HB_CLAMP D(IS=1e-15 N=0.01)
.ends HB_OPAMP
.control
run
meas tran t_first when v(1)=0 rise=1 td=150m
meas tran t_last when v(1)=0 rise=41 td=150m
let f_o = 40 / (t_last - t_first)
print f_o
meas tran e_high max v(1) from=150m to=200m
meas tran e_low min v(1) from=150m to=200m
meas tran early_high max v(1) from=100m to=110m
meas tran summing_peak max v(3) from=150m to=200m
.endc
.end
