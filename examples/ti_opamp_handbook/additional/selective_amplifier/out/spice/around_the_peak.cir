* selective_amplifier: around_the_peak
* plan for ngspice over sha256:4832a6226f90f2d5941286a5e25f87dfd9e1de9c6a1875cabd5ad30baec6ec45
C1 1 0 100n
C2 3 4 50n
C3 4 5 50n
C4 6 7 50n
* GND1 abstracted; no device emitted
R1 3 1 3.3k
R2 1 5 3.3k
R3 4 0 1.65k
R4 7 3 10k
R5 3 5 330k
* TP1 abstracted; no device emitted
* TP2 abstracted; no device emitted
* U1 abstracted; no device emitted
.options abstol=1e-12
.options method=gear
.options reltol=1e-3
.options vntol=1e-6
.ac lin 3001 900 1050
* added by the bench: the drive, and the parts fang abstracted
VDRIVE_e_in 6 0 DC 0 AC 1
XU1 0 3 5 HB_OPAMP A=1e+06 GBW=1e+07 VOH=13.5 VOL=-13.5 VOS=0
.subckt HB_OPAMP inp inn out A=1e6 GBW=1e7 VOH=13.5 VOL=-13.5 VOS=0
VOS inp x DC {VOS}
RIN x inn 1e12
GM 0 n1 x inn 1e-3
R1 n1 0 {A*1e3}
C1 n1 0 {1e-3/(6.283185307179586*GBW)}
DH n1 h HB_CLAMP
VH h 0 DC {VOH}
DL l n1 HB_CLAMP
VL l 0 DC {VOL}
EO out 0 n1 0 1
.model HB_CLAMP D(IS=1e-15 N=0.01)
.ends HB_OPAMP
.control
run
meas ac gain_notch find vm(5) at=964.57
meas ac v_r_i find vm(7) at=964.57
let z_in_notch = 10000 / v_r_i
print z_in_notch
meas ac gain_peak max vm(5)
meas ac gain_peak_db max vdb(5)
let half_power = gain_peak * 0.70711
print half_power
meas ac f_low when vm(5)=half_power rise=1
meas ac f_high when vm(5)=half_power fall=1
let f_centre = sqrt(f_low * f_high)
print f_centre
.endc
.end
