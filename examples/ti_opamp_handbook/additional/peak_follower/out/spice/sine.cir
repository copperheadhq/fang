* peak_follower: sine
* plan for ngspice over sha256:fc2b5b42029ca938aaf0a050832b4c9cea2344145465c45019e8d06316f48650
C1 1 0 1u
* D1 abstracted; no device emitted
* GND1 abstracted; no device emitted
* SW1 abstracted; no device emitted
* TP1 abstracted; no device emitted
* TP2 abstracted; no device emitted
* U1 abstracted; no device emitted
.options abstol=1e-12
.options method=gear
.options reltol=1e-3
.options vntol=1e-6
.tran 1u 10m
* added by the bench: the drive, and the parts fang abstracted
VDRIVE_e_in 3 0 SIN(0 4 1k)
DD1 3 1 D1N4148
SSW1 1 0 ctl_SW1 0 HB_SWITCH
VSW1_CTL ctl_SW1 0 DC 0
XU1 1 4 4 HB_OPAMP A=1e+06 GBW=1e+07 VOH=13.5 VOL=-13.5 VOS=0
.model D1N4148 D(IS=2.52e-9 RS=0.568 N=1.752 CJO=4e-12 M=0.4 TT=20e-9 BV=100 IBV=100e-6)
.subckt HB_OPAMP inp inn out A=1e6 GBW=1e7 VOH=13.5 VOL=-13.5 VOS=0
VOS inp x DC {VOS}
RIN x inn 1e12
GM 0 n1 x inn 1e-3
R1 n1 0 {A*1e3}
C1 n1 0 {1e-3/(6.283185307179586*GBW)}
DH n1 h HB_CLAMP
VH h 0 DC {VOH}
DL l n1 HB_CLAMP
VL l 0 DC {VOL}
EO out 0 n1 0 1
.model HB_CLAMP D(IS=1e-15 N=0.01)
.ends HB_OPAMP
.model HB_SWITCH SW(VT=0.5 VH=0.1 RON=1 ROFF=1e12)
.control
run
meas tran held find v(4) at=9.5m
meas tran input_peak max v(3) from=0 to=10m
.endc
.end
