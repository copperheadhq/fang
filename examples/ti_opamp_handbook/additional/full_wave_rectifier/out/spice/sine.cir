* full_wave_rectifier: sine
* plan for ngspice over sha256:43e0f6f0358e90098b407a40090f53cbbff86e691b1a1f1dd685e12e6724aa28
* D1 abstracted; no device emitted
* D2 abstracted; no device emitted
* GND1 abstracted; no device emitted
R1 5 6 2k
R2 3 6 1k
R3 7 3 1k
R4 5 7 1k
R5 7 1 1k
R6 6 8 2k
* TP1 abstracted; no device emitted
* TP2 abstracted; no device emitted
* U1 abstracted; no device emitted
* U2 abstracted; no device emitted
.options abstol=1e-12
.options method=gear
.options reltol=1e-3
.options vntol=1e-6
.tran 1u 3m
* added by the bench: the drive, and the parts fang abstracted
VDRIVE_e_in 5 0 SIN(0 1 1k)
DD1 1 2 D1N4148
DD2 2 3 D1N4148
XU1 0 7 2 HB_OPAMP A=1e+06 GBW=1e+07 VOH=13.5 VOL=-13.5 VOS=0
XU2 0 6 8 HB_OPAMP A=1e+06 GBW=1e+07 VOH=13.5 VOL=-13.5 VOS=0
.model D1N4148 D(IS=2.52e-9 RS=0.568 N=1.752 CJO=4e-12 M=0.4 TT=20e-9 BV=100 IBV=100e-6)
.subckt HB_OPAMP inp inn out A=1e6 GBW=1e7 VOH=13.5 VOL=-13.5 VOS=0
VOS inp x DC {VOS}
RIN x inn 1e12
GM 0 n1 x inn 1e-3
R1 n1 0 {A*1e3}
C1 n1 0 {1e-3/(6.283185307179586*GBW)}
DH n1 h HB_CLAMP
VH h 0 DC {VOH}
DL l n1 HB_CLAMP
VL l 0 DC {VOL}
EO out 0 n1 0 1
.model HB_CLAMP D(IS=1e-15 N=0.01)
.ends HB_OPAMP
.control
run
meas tran e_min min v(8) from=1m to=3m
meas tran e_average avg v(8) from=1m to=3m
.endc
.end
