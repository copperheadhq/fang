* ac_to_dc_converter: six_volts
* plan for ngspice over sha256:3a6286496db7347c19dd85c01d78befeda899ea1d9652ef9b62bf0a1bd16c95b
C1 1 2 100u
* D1 abstracted; no device emitted
* D2 abstracted; no device emitted
* GND1 abstracted; no device emitted
R1 7 8 10k
R2 8 3 10k
R3 7 1 10k
R4 8 5 10k
R5 3 1 5k
R6 1 9 10k
* RV1 abstracted; no device emitted
* TP1 abstracted; no device emitted
* TP2 abstracted; no device emitted
* U1 abstracted; no device emitted
* U2 abstracted; no device emitted
.options abstol=1e-12
.options method=gear
.options reltol=1e-3
.options vntol=1e-6
.tran 50u 10
* added by the bench: the drive, and the parts fang abstracted
VDRIVE_e_in 7 0 SIN(0 8.485281 100)
DD1 3 4 D1N4148
DD2 4 5 D1N4148
RRV1_A 9 2 0.001
RRV1_B 2 2 2000
XU1 0 8 4 HB_OPAMP A=1e+06 GBW=1e+07 VOH=13.5 VOL=-13.5 VOS=0
XU2 0 1 2 HB_OPAMP A=1e+06 GBW=1e+07 VOH=13.5 VOL=-13.5 VOS=0
.model D1N4148 D(IS=2.52e-9 RS=0.568 N=1.752 CJO=4e-12 M=0.4 TT=20e-9 BV=100 IBV=100e-6)
.subckt HB_OPAMP inp inn out A=1e6 GBW=1e7 VOH=13.5 VOL=-13.5 VOS=0
VOS inp x DC {VOS}
RIN x inn 1e12
GM 0 n1 x inn 1e-3
R1 n1 0 {A*1e3}
C1 n1 0 {1e-3/(6.283185307179586*GBW)}
DH n1 h HB_CLAMP
VH h 0 DC {VOH}
DL l n1 HB_CLAMP
VL l 0 DC {VOL}
EO out 0 n1 0 1
.model HB_CLAMP D(IS=1e-15 N=0.01)
.ends HB_OPAMP
.control
run
meas tran e_average avg v(2) from=9 to=10
meas tran ripple pp v(2) from=9 to=10
let k_measured = e_average / 6
print k_measured
.endc
.end
