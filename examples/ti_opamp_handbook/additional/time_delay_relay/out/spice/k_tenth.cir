* time_delay_relay: k_tenth
* plan for ngspice over sha256:7946b303cbec9cd67e4801f8a9b476a0bc0f4f9fefa9a7ee3403c6bd219b0635
C1 1 2 10u
* D1 abstracted; no device emitted
* D2 abstracted; no device emitted
* D3 abstracted; no device emitted
* GND1 abstracted; no device emitted
* M1 abstracted; no device emitted
R1 7 1 100k
R2 3 8 4.7k
R3 9 3 10k
R4 2 0 10k
R5 9 5 10k
* RV1 abstracted; no device emitted
* SW1 abstracted; no device emitted
* U1 abstracted; no device emitted
V1 9 0 15
.options abstol=1e-12
.options method=gear
.options reltol=1e-3
.options vntol=1e-6
.tran 1m 6
* added by the bench: the drive, and the parts fang abstracted
DD1 1 3 D1N4148
DD2 4 5 D1N4148
DD3 5 2 D1N4148
RM1 0 sense_M1 1000
VM1_SENSE sense_M1 4 DC 0
RRV1_A 0 7 1000
RRV1_B 7 9 9000
SSW1 5 8 ctl_SW1 0 HB_SWITCH
VSW1_CTL ctl_SW1 0 PWL(0 0 0.1 0 0.1001 1)
XU1 0 1 8 HB_OPAMP A=1e+06 GBW=1e+07 VOH=13.5 VOL=-13.5 VOS=0
.model D1N4148 D(IS=2.52e-9 RS=0.568 N=1.752 CJO=4e-12 M=0.4 TT=20e-9 BV=100 IBV=100e-6)
.subckt HB_OPAMP inp inn out A=1e6 GBW=1e7 VOH=13.5 VOL=-13.5 VOS=0
VOS inp x DC {VOS}
RIN x inn 1e12
GM 0 n1 x inn 1e-3
R1 n1 0 {A*1e3}
C1 n1 0 {1e-3/(6.283185307179586*GBW)}
DH n1 h HB_CLAMP
VH h 0 DC {VOH}
DL l n1 HB_CLAMP
VL l 0 DC {VOL}
EO out 0 n1 0 1
.model HB_CLAMP D(IS=1e-15 N=0.01)
.ends HB_OPAMP
.model HB_SWITCH SW(VT=0.5 VH=0.1 RON=1 ROFF=1e12)
.control
run
meas tran t_reset find v(2) at=0.09
meas tran coil_reset find i(vm1_sense) at=0.09
meas tran coil_peak_early max i(vm1_sense) from=0.1 to=0.15
meas tran t_pull_in when i(vm1_sense)=4.5m rise=1
let delay_measured = t_pull_in - 0.1
print delay_measured
meas tran coil_on find i(vm1_sense) at=6
.endc
.end
