* clamped_comparator: transfer
* plan for ngspice over sha256:7c17811651e162246344b919e5e875446e8189fdb21509ae42f957ea6d643ac6
* D1 abstracted; no device emitted
* D2 abstracted; no device emitted
* GND1 abstracted; no device emitted
R1 5 1 100k
R2 6 1 1Meg
R3 7 2 15k
R4 3 8 15k
R5 2 9 10k
R6 9 3 3k
* TP1 abstracted; no device emitted
* TP2 abstracted; no device emitted
* TP3 abstracted; no device emitted
* TP4 abstracted; no device emitted
* TP5 abstracted; no device emitted
* U1 abstracted; no device emitted
V1 0 8 15
V2 7 0 15
V3 0 6 15
.options abstol=1e-12
.options method=gear
.options reltol=1e-3
.options vntol=1e-6
.dc VDRIVE_e_in -3 5 1m
* added by the bench: the drive, and the parts fang abstracted
VDRIVE_e_in 5 0 DC 0
DD1 1 2 D1N4148
DD2 3 1 D1N4148
XU1 0 1 9 HB_OPAMP A=1e+06 GBW=1e+07 VOH=13.5 VOL=-13.5 VOS=0
.model D1N4148 D(IS=2.52e-9 RS=0.568 N=1.752 CJO=4e-12 M=0.4 TT=20e-9 BV=100 IBV=100e-6)
.subckt HB_OPAMP inp inn out A=1e6 GBW=1e7 VOH=13.5 VOL=-13.5 VOS=0
VOS inp x DC {VOS}
RIN x inn 1e12
GM 0 n1 x inn 1e-3
R1 n1 0 {A*1e3}
C1 n1 0 {1e-3/(6.283185307179586*GBW)}
DH n1 h HB_CLAMP
VH h 0 DC {VOH}
DL l n1 HB_CLAMP
VL l 0 DC {VOL}
EO out 0 n1 0 1
.model HB_CLAMP D(IS=1e-15 N=0.01)
.ends HB_OPAMP
.control
run
meas dc e_i_at_switch when v(9)=-3.645 fall=1
meas dc e_out_at_1v find v(9) at=1
meas dc e_out_at_2v find v(9) at=2
.endc
.end
