* deflection_coil_driver: dc
* plan for ngspice over sha256:a3f0b399146da18db2b5f6f9cc199287f28751568fddfb445b429cf5ef14f1bf
* GND1 abstracted; no device emitted
L1 2 3 10m
R1 4 2 5
R2 5 3 10k
R3 6 5 10k
R4 3 0 10
* TP1 abstracted; no device emitted
* U1 abstracted; no device emitted
.options abstol=1e-12
.options method=gear
.options reltol=1e-3
.options vntol=1e-6
.op
* added by the bench: the drive, and the parts fang abstracted
VDRIVE_e_in 6 0 DC 1
XU1 0 5 4 HB_OPAMP A=1e+06 GBW=1e+07 VOH=13.5 VOL=-13.5 VOS=0
.subckt HB_OPAMP inp inn out A=1e6 GBW=1e7 VOH=13.5 VOL=-13.5 VOS=0
VOS inp x DC {VOS}
RIN x inn 1e12
GM 0 n1 x inn 1e-3
R1 n1 0 {A*1e3}
C1 n1 0 {1e-3/(6.283185307179586*GBW)}
DH n1 h HB_CLAMP
VH h 0 DC {VOH}
DL l n1 HB_CLAMP
VL l 0 DC {VOL}
EO out 0 n1 0 1
.model HB_CLAMP D(IS=1e-15 N=0.01)
.ends HB_OPAMP
.control
run
let i_per_volt = i(l1) / v(6)
print i_per_volt
let e_out = v(4)
print e_out
.endc
.end
