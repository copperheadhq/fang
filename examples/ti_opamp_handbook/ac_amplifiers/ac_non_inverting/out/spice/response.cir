* ac_non_inverting: response
* plan for ngspice over sha256:a8b6b7c6d2a4824ee3d88ed7b18504daf9f5c949d4d9c226d6bf30adca2e6167
C1 1 0 100u
C2 3 4 1u
* GND1 abstracted; no device emitted
R1 5 6 90k
R2 5 1 10k
R3 4 0 100k
* TP1 abstracted; no device emitted
* TP2 abstracted; no device emitted
* U1 abstracted; no device emitted
.options abstol=1e-12
.options method=gear
.options reltol=1e-3
.options vntol=1e-6
.ac dec 40 0.001 10meg
* added by the bench: the drive, and the parts fang abstracted
VDRIVE_e_in 3 0 DC 0 AC 1
XU1 4 5 6 HB_OPAMP A=1e+06 GBW=1e+07 VOH=13.5 VOL=-13.5 VOS=0
.subckt HB_OPAMP inp inn out A=1e6 GBW=1e7 VOH=13.5 VOL=-13.5 VOS=0
VOS inp x DC {VOS}
RIN x inn 1e12
GM 0 n1 x inn 1e-3
R1 n1 0 {A*1e3}
C1 n1 0 {1e-3/(6.283185307179586*GBW)}
DH n1 h HB_CLAMP
VH h 0 DC {VOH}
DL l n1 HB_CLAMP
VL l 0 DC {VOL}
EO out 0 n1 0 1
.model HB_CLAMP D(IS=1e-15 N=0.01)
.ends HB_OPAMP
.control
run
meas ac gain_1k find vm(6) at=1k
meas ac phase_1k find vp(6) at=1k
meas ac f_3db when vdb(6)=16.9897 cross=1
meas ac out_at_gain_corner find vm(6) at=0.159155
meas ac plus_at_gain_corner find vm(4) at=0.159155
let gain_network = out_at_gain_corner / plus_at_gain_corner
print gain_network
meas ac plus_at_input_corner find vm(4) at=1.59155
.endc
.end
