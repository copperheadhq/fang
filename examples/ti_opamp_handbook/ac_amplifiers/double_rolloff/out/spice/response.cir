* double_rolloff: response
* plan for ngspice over sha256:2e7fd4f265f6462e9353c8439b900e08889157dd65be286a50e77ada3f30484c
C1 1 2 100u
C2 3 4 1u
* GND1 abstracted; no device emitted
R1 1 6 90k
R2 2 0 10k
R3 4 2 100k
* TP1 abstracted; no device emitted
* TP2 abstracted; no device emitted
* U1 abstracted; no device emitted
.options abstol=1e-12
.options method=gear
.options reltol=1e-3
.options vntol=1e-6
.ac dec 200 0.0001 10meg
* added by the bench: the drive, and the parts fang abstracted
VDRIVE_e_in 3 0 DC 0 AC 1
XU1 4 1 6 HB_OPAMP A=1e+06 GBW=1e+07 VOH=13.5 VOL=-13.5 VOS=0
.subckt HB_OPAMP inp inn out A=1e6 GBW=1e7 VOH=13.5 VOL=-13.5 VOS=0
VOS inp x DC {VOS}
RIN x inn 1e12
GM 0 n1 x inn 1e-3
R1 n1 0 {A*1e3}
C1 n1 0 {1e-3/(6.283185307179586*GBW)}
DH n1 h HB_CLAMP
VH h 0 DC {VOH}
DL l n1 HB_CLAMP
VL l 0 DC {VOL}
EO out 0 n1 0 1
.model HB_CLAMP D(IS=1e-15 N=0.01)
.ends HB_OPAMP
.control
run
meas ac gain_1k find vm(6) at=1k
meas ac peak max vm(6) from=0.01 to=100
meas ac g_005 find vm(6) at=0.05
meas ac g_015 find vm(6) at=0.15
let slope_steep = 20 * log10(g_015 / g_005) / log10(3)
print slope_steep
meas ac g_0001 find vm(6) at=0.001
meas ac g_001 find vm(6) at=0.01
let slope_low = 20 * log10(g_001 / g_0001)
print slope_low
meas ac f_3db when vdb(6)=16.9897 cross=1
.endc
.end
