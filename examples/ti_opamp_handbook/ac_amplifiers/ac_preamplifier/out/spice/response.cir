* ac_preamplifier: response
* plan for ngspice over sha256:4ff23d07c39ec07f82599a1ba528ba52c2d60d25acc127680711382a68edec2f
C1 1 2 1000u
C2 3 4 1u
C3 5 6 10u
* GND1 abstracted; no device emitted
R1 1 5 100k
R2 2 0 200
R3 4 2 100k
R4 2 8 2.2k
R5 6 0 100k
* RV1 abstracted; no device emitted
* TP1 abstracted; no device emitted
* TP2 abstracted; no device emitted
* U1 abstracted; no device emitted
.options abstol=1e-12
.options method=gear
.options reltol=1e-3
.options vntol=1e-6
.ac dec 200 0.001 10meg
* added by the bench: the drive, and the parts fang abstracted
VDRIVE_e_in 3 0 DC 0 AC 1
RRV1_A 8 0 10000
RRV1_B 0 0 0.001
XU1 4 1 5 HB_OPAMP A=1e+06 GBW=1e+07 VOH=13.5 VOL=-13.5 VOS=0
.subckt HB_OPAMP inp inn out A=1e6 GBW=1e7 VOH=13.5 VOL=-13.5 VOS=0
VOS inp x DC {VOS}
RIN x inn 1e12
GM 0 n1 x inn 1e-3
R1 n1 0 {A*1e3}
C1 n1 0 {1e-3/(6.283185307179586*GBW)}
DH n1 h HB_CLAMP
VH h 0 DC {VOH}
DL l n1 HB_CLAMP
VL l 0 DC {VOL}
EO out 0 n1 0 1
.model HB_CLAMP D(IS=1e-15 N=0.01)
.ends HB_OPAMP
.control
run
meas ac gain_100 find vm(6) at=100
meas ac f_3db when vdb(6)=51.1087 cross=1
meas ac peak max vm(6) from=0.01 to=10
meas ac g_01 find vm(5) at=0.1
meas ac g_03 find vm(5) at=0.3
let slope = 20 * log10(g_03 / g_01) / log10(3)
print slope
meas ac p_re find vr(4) at=100
meas ac p_im find vi(4) at=100
meas ac j_re find vr(2) at=100
meas ac j_im find vi(2) at=100
let z_in_100 = 100k / sqrt((p_re - j_re)^2 + (p_im - j_im)^2)
print z_in_100
meas ac f_upper when vdb(6)=51.1087 cross=2
.endc
.end
