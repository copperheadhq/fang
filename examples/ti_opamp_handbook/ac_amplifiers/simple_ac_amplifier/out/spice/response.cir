* simple_ac_amplifier: response
* plan for ngspice over sha256:20f3b623d8af07af2128e9119671e2fb8ef04f3386fa8ffa72c3d954e4a482ea
C1 1 2 1u
* GND1 abstracted; no device emitted
R1 2 4 10k
R2 4 5 100k
* TP1 abstracted; no device emitted
* TP2 abstracted; no device emitted
* U1 abstracted; no device emitted
.options abstol=1e-12
.options method=gear
.options reltol=1e-3
.options vntol=1e-6
.ac dec 40 0.1 10meg
* added by the bench: the drive, and the parts fang abstracted
VDRIVE_e_in 1 0 DC 0 AC 1
XU1 0 4 5 HB_OPAMP A=1e+06 GBW=1e+07 VOH=13.5 VOL=-13.5 VOS=0
.subckt HB_OPAMP inp inn out A=1e6 GBW=1e7 VOH=13.5 VOL=-13.5 VOS=0
VOS inp x DC {VOS}
RIN x inn 1e12
GM 0 n1 x inn 1e-3
R1 n1 0 {A*1e3}
C1 n1 0 {1e-3/(6.283185307179586*GBW)}
DH n1 h HB_CLAMP
VH h 0 DC {VOH}
DL l n1 HB_CLAMP
VL l 0 DC {VOL}
EO out 0 n1 0 1
.model HB_CLAMP D(IS=1e-15 N=0.01)
.ends HB_OPAMP
.control
run
meas ac gain_1k find vm(5) at=1k
meas ac i_in_1k find i(vdrive_e_in) at=1k
let z_in = -1 / i_in_1k
print z_in
meas ac f_3db when vdb(5)=16.9897 cross=1
meas ac gain_1hz find vm(5) at=1
meas ac f_high when vdb(5)=16.9897 cross=2
.endc
.end
