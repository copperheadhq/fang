* double_integrator: drawn
* plan for ngspice over sha256:61b63a41056495231c88dcebbb6f64bdf0f5a972219607b4042620bd7b3225ec
C1 1 0 1u
C2 3 4 1u
C3 4 5 1u
* GND1 abstracted; no device emitted
R1 6 1 1Meg
R2 1 3 1Meg
R3 4 0 10k
* TP1 abstracted; no device emitted
* TP2 abstracted; no device emitted
* U1 abstracted; no device emitted
.options abstol=1e-12
.options method=gear
.options reltol=1e-3
.options vntol=1e-6
.ac dec 20 1m 100
* added by the bench: the drive, and the parts fang abstracted
VDRIVE_e_in 6 0 DC 0 AC 1
XU1 0 3 5 HB_OPAMP A=1e+07 GBW=1e+07 VOH=13.5 VOL=-13.5 VOS=0
.subckt HB_OPAMP inp inn out A=1e6 GBW=1e7 VOH=13.5 VOL=-13.5 VOS=0
VOS inp x DC {VOS}
RIN x inn 1e12
GM 0 n1 x inn 1e-3
R1 n1 0 {A*1e3}
C1 n1 0 {1e-3/(6.283185307179586*GBW)}
DH n1 h HB_CLAMP
VH h 0 DC {VOH}
DL l n1 HB_CLAMP
VL l 0 DC {VOL}
EO out 0 n1 0 1
.model HB_CLAMP D(IS=1e-15 N=0.01)
.ends HB_OPAMP
.control
run
meas ac gain_10mhz find vm(5) at=0.01
let k_low = -gain_10mhz * (2 * pi * 0.01)^2
print k_low
meas ac gain_0hz1 find vm(5) at=0.1
meas ac gain_1hz find vm(5) at=1
.endc
.end
