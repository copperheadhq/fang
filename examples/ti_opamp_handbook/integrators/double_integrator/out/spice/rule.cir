* double_integrator: rule
* plan for ngspice over sha256:3c71f6de600b33bf36676f12f1f425908843d70ca622ccbe8555d68c303459f7
C1 1 0 1u
C2 3 4 1u
C3 4 5 1u
* GND1 abstracted; no device emitted
R1 6 1 1Meg
R2 1 3 1Meg
R3 4 0 10k
* TP1 abstracted; no device emitted
* TP2 abstracted; no device emitted
* U1 abstracted; no device emitted
.options abstol=1e-12
.options method=gear
.options reltol=1e-3
.options vntol=1e-6
.ac dec 20 1m 100
* added by the bench: the drive, and the parts fang abstracted
VDRIVE_e_in 6 0 DC 0 AC 1
XU1 0 3 5 HB_OPAMP A=1e+07 GBW=1e+07 VOH=13.5 VOL=-13.5 VOS=0
* the rule's values, C_O = C_I/2 and R_O = R_I/2, beside the drawn circuit
RRULE_I1 6 rule_t 1meg
RRULE_I2 rule_t rule_sum 1meg
CRULE_I rule_t 0 1u
CRULE_O1 rule_sum rule_b 0.5u
CRULE_O2 rule_b rule_out 0.5u
RRULE_O rule_b 0 500k
XRULE 0 rule_sum rule_out HB_OPAMP A=1e+07 GBW=1e+07 VOH=13.5 VOL=-13.5 VOS=0
.subckt HB_OPAMP inp inn out A=1e6 GBW=1e7 VOH=13.5 VOL=-13.5 VOS=0
VOS inp x DC {VOS}
RIN x inn 1e12
GM 0 n1 x inn 1e-3
R1 n1 0 {A*1e3}
C1 n1 0 {1e-3/(6.283185307179586*GBW)}
DH n1 h HB_CLAMP
VH h 0 DC {VOH}
DL l n1 HB_CLAMP
VL l 0 DC {VOL}
EO out 0 n1 0 1
.model HB_CLAMP D(IS=1e-15 N=0.01)
.ends HB_OPAMP
.control
run
meas ac gain_0hz1 find vm(rule_out) at=0.1
let k_0hz1 = -gain_0hz1 * (2 * pi * 0.1)^2
print k_0hz1
meas ac gain_1hz find vm(rule_out) at=1
let k_1hz = -gain_1hz * (2 * pi * 1)^2
print k_1hz
meas ac phase_rad find vp(rule_out) at=1
.endc
.end
