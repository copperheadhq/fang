* integrator: ramp
* plan for ngspice over sha256:0cffdaf1b65c26d0dd44ecc1baf62db7e08f1547bc74972d34b1b93332467e77
C1 1 2 0.1u
* GND1 abstracted; no device emitted
R1 4 1 10k
* TP1 abstracted; no device emitted
* TP2 abstracted; no device emitted
* U1 abstracted; no device emitted
.options abstol=1e-12
.options method=gear
.options reltol=1e-3
.options vntol=1e-6
.tran 10u 10m
* added by the bench: the drive, and the parts fang abstracted
VDRIVE_e_in 4 0 DC 0.01
XU1 0 1 2 HB_OPAMP A=1e+06 GBW=1e+07 VOH=13.5 VOL=-13.5 VOS=0
.ic v(2)=0 v(1)=0
.subckt HB_OPAMP inp inn out A=1e6 GBW=1e7 VOH=13.5 VOL=-13.5 VOS=0
VOS inp x DC {VOS}
RIN x inn 1e12
GM 0 n1 x inn 1e-3
R1 n1 0 {A*1e3}
C1 n1 0 {1e-3/(6.283185307179586*GBW)}
DH n1 h HB_CLAMP
VH h 0 DC {VOH}
DL l n1 HB_CLAMP
VL l 0 DC {VOL}
EO out 0 n1 0 1
.model HB_CLAMP D(IS=1e-15 N=0.01)
.ends HB_OPAMP
.control
run
meas tran e_1ms find v(2) at=1m
meas tran e_9ms find v(2) at=9m
let rate_per_volt = (e_9ms - e_1ms) / 8m / 0.01
print rate_per_volt
.endc
.end
