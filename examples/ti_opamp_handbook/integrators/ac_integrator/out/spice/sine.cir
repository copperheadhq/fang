* ac_integrator: sine
* plan for ngspice over sha256:8935583c17619f39c6c5d9d52f68a503346b058ee0b0d4a4b4c52c318b31aabf
C1 1 0 100u
C2 3 4 0.01u
* GND1 abstracted; no device emitted
R1 5 1 100k
R2 6 3 100k
* SW1 abstracted; no device emitted
* TP1 abstracted; no device emitted
* TP2 abstracted; no device emitted
* U1 abstracted; no device emitted
.options abstol=1e-12
.options method=gear
.options reltol=1e-3
.options vntol=1e-6
.ac dec 50 1m 100k
* added by the bench: the drive, and the parts fang abstracted
VDRIVE_e_in 6 0 DC 0 AC 1
SSW1 3 4 ctl_SW1 0 HB_SWITCH
VSW1_CTL ctl_SW1 0 DC 0
XU1 1 3 4 5 HB_FDA A=1e+06 GBW=1e+07 VOH=13.5 VOL=-13.5 VOS=0
.subckt HB_FDA inp inn outp outn A=1e6 GBW=1e7 VOH=13.5 VOL=-13.5 VOS=0
XHALF inp inn half HB_OPAMP A={A} GBW={GBW} VOH={VOH} VOL={VOL} VOS={VOS}
EP outp 0 half 0 0.5
EN outn 0 half 0 -0.5
.ends HB_FDA
.subckt HB_OPAMP inp inn out A=1e6 GBW=1e7 VOH=13.5 VOL=-13.5 VOS=0
VOS inp x DC {VOS}
RIN x inn 1e12
GM 0 n1 x inn 1e-3
R1 n1 0 {A*1e3}
C1 n1 0 {1e-3/(6.283185307179586*GBW)}
DH n1 h HB_CLAMP
VH h 0 DC {VOH}
DL l n1 HB_CLAMP
VL l 0 DC {VOL}
EO out 0 n1 0 1
.model HB_CLAMP D(IS=1e-15 N=0.01)
.ends HB_OPAMP
.model HB_SWITCH SW(VT=0.5 VH=0.1 RON=1 ROFF=1e12)
.control
run
meas ac gain_unity find vm(4) at=159.155
meas ac gain_100hz find vm(4) at=100
meas ac phase_rad find vp(4) at=100
let phase_deg = phase_rad * 180 / pi
print phase_deg
meas ac gain_1mhz find vm(4) at=0.001
meas ac peak max vm(4)
meas ac f_peak when vm(4)=peak
.endc
.end
