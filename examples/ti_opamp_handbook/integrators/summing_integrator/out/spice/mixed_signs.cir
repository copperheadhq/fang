* summing_integrator: mixed_signs
* plan for ngspice over sha256:97f7698c80f1e592121f4a2e134ae41a8733ffe425f12f489e840256170583cf
C1 1 2 1u
* GND1 abstracted; no device emitted
R1 4 1 100k
R2 5 1 100k
R3 6 1 100k
* SW1 abstracted; no device emitted
* TP1 abstracted; no device emitted
* TP2 abstracted; no device emitted
* TP3 abstracted; no device emitted
* TP4 abstracted; no device emitted
* U1 abstracted; no device emitted
.options abstol=1e-12
.options method=gear
.options reltol=1e-3
.options vntol=1e-6
.tran 1m 1.1
* added by the bench: the drive, and the parts fang abstracted
VDRIVE_e1 4 0 DC 0.5
VDRIVE_e2 5 0 DC -0.2
VDRIVE_e3 6 0 DC 0.1
SSW1 1 2 ctl_SW1 0 HB_SWITCH
VSW1_CTL ctl_SW1 0 PWL(0 1 10m 1 10.001m 0)
XU1 0 1 2 HB_OPAMP A=1e+06 GBW=1e+07 VOH=13.5 VOL=-13.5 VOS=0
.subckt HB_OPAMP inp inn out A=1e6 GBW=1e7 VOH=13.5 VOL=-13.5 VOS=0
VOS inp x DC {VOS}
RIN x inn 1e12
GM 0 n1 x inn 1e-3
R1 n1 0 {A*1e3}
C1 n1 0 {1e-3/(6.283185307179586*GBW)}
DH n1 h HB_CLAMP
VH h 0 DC {VOH}
DL l n1 HB_CLAMP
VL l 0 DC {VOL}
EO out 0 n1 0 1
.model HB_CLAMP D(IS=1e-15 N=0.01)
.ends HB_OPAMP
.model HB_SWITCH SW(VT=0.5 VH=0.1 RON=1 ROFF=1e12)
.control
run
meas tran e_early find v(2) at=0.1
meas tran e_late find v(2) at=1.1
let rate_per_volt = (e_late - e_early) / 1.0 / 0.4
print rate_per_volt
.endc
.end
