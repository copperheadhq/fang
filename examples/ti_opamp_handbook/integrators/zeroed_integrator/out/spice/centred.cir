* zeroed_integrator: centred
* plan for ngspice over sha256:b2625a650a1a2b70f463288ce5a9e5fb06242de2bb7ecf4d54a85662d20451aa
C1 1 2 1u
* GND1 abstracted; no device emitted
R1 4 1 100k
R2 5 6 10k
R3 7 8 10k
R4 9 1 10Meg
* RV1 abstracted; no device emitted
* SW1 abstracted; no device emitted
* TP1 abstracted; no device emitted
* TP2 abstracted; no device emitted
* TP3 abstracted; no device emitted
* TP4 abstracted; no device emitted
* U1 abstracted; no device emitted
.options abstol=1e-12
.options method=gear
.options reltol=1e-3
.options vntol=1e-6
.tran 1m 1.1
* added by the bench: the drive, and the parts fang abstracted
VDRIVE_e_in 4 0 DC 0
VDRIVE_rail_minus 7 0 DC -15
VDRIVE_rail_plus 5 0 DC 15
RRV1_A 6 9 5000
RRV1_B 9 8 5000
SSW1 1 2 ctl_SW1 0 HB_SWITCH
VSW1_CTL ctl_SW1 0 PWL(0 1 10m 1 10.001m 0)
XU1 0 1 2 HB_OPAMP A=1e+06 GBW=1e+07 VOH=13.5 VOL=-13.5 VOS=0.001
.subckt HB_OPAMP inp inn out A=1e6 GBW=1e7 VOH=13.5 VOL=-13.5 VOS=0
VOS inp x DC {VOS}
RIN x inn 1e12
GM 0 n1 x inn 1e-3
R1 n1 0 {A*1e3}
C1 n1 0 {1e-3/(6.283185307179586*GBW)}
DH n1 h HB_CLAMP
VH h 0 DC {VOH}
DL l n1 HB_CLAMP
VL l 0 DC {VOL}
EO out 0 n1 0 1
.model HB_CLAMP D(IS=1e-15 N=0.01)
.ends HB_OPAMP
.model HB_SWITCH SW(VT=0.5 VH=0.1 RON=1 ROFF=1e12)
.control
run
meas tran e_early find v(2) at=0.1
meas tran e_late find v(2) at=1.1
let drift = (e_late - e_early) / 1.0
print drift
meas tran wiper find v(9) at=0.5
.endc
.end
