* simple_non_inverting: swing
* plan for ngspice over sha256:1cc447b9bb7b138367efbb9bf8f811d9be4c68fbf5c55fe81f61ddb6c12ad3ef
* GND1 abstracted; no device emitted
R1 2 0 10k
R2 2 3 90k
* TP1 abstracted; no device emitted
* TP2 abstracted; no device emitted
* U1 abstracted; no device emitted
.options abstol=1e-12
.options method=gear
.options reltol=1e-3
.options vntol=1e-6
.dc VDRIVE_e_in -2 2 0.01
* added by the bench: the drive, and the parts fang abstracted
VDRIVE_e_in 4 0 DC 0
XU1 4 2 3 HB_OPAMP A=1e+06 GBW=1e+07 VOH=13.5 VOL=-13.5 VOS=0
.subckt HB_OPAMP inp inn out A=1e6 GBW=1e7 VOH=13.5 VOL=-13.5 VOS=0
VOS inp x DC {VOS}
RIN x inn 1e12
GM 0 n1 x inn 1e-3
R1 n1 0 {A*1e3}
C1 n1 0 {1e-3/(6.283185307179586*GBW)}
DH n1 h HB_CLAMP
VH h 0 DC {VOH}
DL l n1 HB_CLAMP
VL l 0 DC {VOL}
EO out 0 n1 0 1
.model HB_CLAMP D(IS=1e-15 N=0.01)
.ends HB_OPAMP
.control
run
meas dc e_out_top max v(3)
meas dc e_out_bottom min v(3)
meas dc gain_at_1v find v(3) at=1
.endc
.end
