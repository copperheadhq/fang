* simple_gain_control: wiper_centre
* plan for ngspice over sha256:a5835a1fe695db61fbfaeb4e1a748fcbb74ce527e3666089b21d6ff72ea120c6
* GND1 abstracted; no device emitted
* RV1 abstracted; no device emitted
* TP1 abstracted; no device emitted
* TP2 abstracted; no device emitted
* U1 abstracted; no device emitted
.options abstol=1e-12
.options method=gear
.options reltol=1e-3
.options vntol=1e-6
.op
* added by the bench: the drive, and the parts fang abstracted
VDRIVE_e_in 2 0 DC 0.1
RRV1_A 2 3 5000
RRV1_B 3 4 5000
XU1 0 3 4 HB_OPAMP A=1e+06 GBW=1e+07 VOH=13.5 VOL=-13.5 VOS=0
.subckt HB_OPAMP inp inn out A=1e6 GBW=1e7 VOH=13.5 VOL=-13.5 VOS=0
VOS inp x DC {VOS}
RIN x inn 1e12
GM 0 n1 x inn 1e-3
R1 n1 0 {A*1e3}
C1 n1 0 {1e-3/(6.283185307179586*GBW)}
DH n1 h HB_CLAMP
VH h 0 DC {VOH}
DL l n1 HB_CLAMP
VL l 0 DC {VOL}
EO out 0 n1 0 1
.model HB_CLAMP D(IS=1e-15 N=0.01)
.ends HB_OPAMP
.control
run
let gain = v(4) / v(2)
print gain
let z_in = -v(2) / i(vdrive_e_in)
print z_in
.endc
.end
