* low_noise_differentiator: response
* plan for ngspice over sha256:78302d128bc7071ac6de815293df4873bf30c865e4f3b9fbbb50ac88a40d51c9
C1 1 2 0.1u
C2 2 3 1n
* GND1 abstracted; no device emitted
R1 5 1 1k
R2 2 3 100k
* TP1 abstracted; no device emitted
* TP2 abstracted; no device emitted
* TP3 abstracted; no device emitted
* U1 abstracted; no device emitted
.options abstol=1e-12
.options method=gear
.options reltol=1e-3
.options vntol=1e-6
.ac dec 200 1 1meg
* added by the bench: the drive, and the parts fang abstracted
VDRIVE_e_in 5 0 DC 0 AC 1
XU1 0 2 3 HB_OPAMP A=1e+06 GBW=1e+07 VOH=13.5 VOL=-13.5 VOS=0
.subckt HB_OPAMP inp inn out A=1e6 GBW=1e7 VOH=13.5 VOL=-13.5 VOS=0
VOS inp x DC {VOS}
RIN x inn 1e12
GM 0 n1 x inn 1e-3
R1 n1 0 {A*1e3}
C1 n1 0 {1e-3/(6.283185307179586*GBW)}
DH n1 h HB_CLAMP
VH h 0 DC {VOH}
DL l n1 HB_CLAMP
VL l 0 DC {VOL}
EO out 0 n1 0 1
.model HB_CLAMP D(IS=1e-15 N=0.01)
.ends HB_OPAMP
.control
run
meas ac f_unity when vm(3)=1
meas ac gain_corner find vm(3) at=1591.55
meas ac gain_peak max vm(3)
meas ac gain_decade find vm(3) at=15915.5
meas ac f_unity_high when vm(3)=1 fall=1
.endc
.end
