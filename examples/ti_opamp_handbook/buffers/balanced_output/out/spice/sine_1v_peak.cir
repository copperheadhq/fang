* balanced_output: sine_1v_peak
* plan for ngspice over sha256:b9e7c2ed3e4a9fe3a3f6ca6f6fb0b5a4108f16994d739f39e7a2935c125c56a8
* GND1 abstracted; no device emitted
R1 2 3 10k
R2 4 5 10k
R3 3 4 10k
R4 5 6 10k
* TP1 abstracted; no device emitted
* TP2 abstracted; no device emitted
* TP3 abstracted; no device emitted
* TP4 abstracted; no device emitted
* TP5 abstracted; no device emitted
* U1 abstracted; no device emitted
* U2 abstracted; no device emitted
.options abstol=1e-12
.options method=gear
.options reltol=1e-3
.options vntol=1e-6
.tran 1u 3m
* added by the bench: the drive, and the parts fang abstracted
VDRIVE_e_in 2 0 SIN(0 1 1k)
XU1 0 3 4 HB_OPAMP A=1e+06 GBW=1e+07 VOH=13.5 VOL=-13.5 VOS=0
XU2 0 5 6 HB_OPAMP A=1e+06 GBW=1e+07 VOH=13.5 VOL=-13.5 VOS=0
EDIFF_PROBE diff_probe 0 4 6 1
.subckt HB_OPAMP inp inn out A=1e6 GBW=1e7 VOH=13.5 VOL=-13.5 VOS=0
VOS inp x DC {VOS}
RIN x inn 1e12
GM 0 n1 x inn 1e-3
R1 n1 0 {A*1e3}
C1 n1 0 {1e-3/(6.283185307179586*GBW)}
DH n1 h HB_CLAMP
VH h 0 DC {VOH}
DL l n1 HB_CLAMP
VL l 0 DC {VOL}
EO out 0 n1 0 1
.model HB_CLAMP D(IS=1e-15 N=0.01)
.ends HB_OPAMP
.control
run
meas tran pp_diff pp v(diff_probe) from=1m to=3m
meas tran pp_plus pp v(4) from=1m to=3m
meas tran max_plus max v(4) from=1m to=3m
meas tran max_minus max v(6) from=1m to=3m
.endc
.end
