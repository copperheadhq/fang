* reference_voltage_supply: outputs
* plan for ngspice over sha256:84ca4e8d05b9dd2a63ca4a359e0542e51a0928aa11284296e5b66b7e6dd3d77d
* GND1 abstracted; no device emitted
R1 2 3 100k
R2 4 2 10k
R3 5 6 10k
R4 3 5 10k
R5 4 6 90k
* TP1 abstracted; no device emitted
* TP2 abstracted; no device emitted
* TP3 abstracted; no device emitted
* U1 abstracted; no device emitted
* U2 abstracted; no device emitted
V1 4 0 1.0183
.options abstol=1e-12
.options method=gear
.options reltol=1e-3
.options vntol=1e-6
.op
* added by the bench: the drive, and the parts fang abstracted
XU1 0 2 3 HB_OPAMP A=1e+06 GBW=1e+07 VOH=13.5 VOL=-13.5 VOS=0
XU2 0 5 6 HB_OPAMP A=1e+06 GBW=1e+07 VOH=13.5 VOL=-13.5 VOS=0
.subckt HB_OPAMP inp inn out A=1e6 GBW=1e7 VOH=13.5 VOL=-13.5 VOS=0
VOS inp x DC {VOS}
RIN x inn 1e12
GM 0 n1 x inn 1e-3
R1 n1 0 {A*1e3}
C1 n1 0 {1e-3/(6.283185307179586*GBW)}
DH n1 h HB_CLAMP
VH h 0 DC {VOH}
DL l n1 HB_CLAMP
VL l 0 DC {VOL}
EO out 0 n1 0 1
.model HB_CLAMP D(IS=1e-15 N=0.01)
.ends HB_OPAMP
.control
run
let e_out_minus = v(3)
print e_out_minus
let e_out_plus = v(6)
print e_out_plus
let i_r1 = (v(4) - v(2)) / 10e3
print i_r1
let i_cell = -i(v1)
print i_cell
.endc
.end
