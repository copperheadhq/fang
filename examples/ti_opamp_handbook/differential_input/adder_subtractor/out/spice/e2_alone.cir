* adder_subtractor: e2_alone
* plan for ngspice over sha256:20214dee37dcf3f266296f3aebc03dca0cfa37d0169d7ee8318571c970c640a2
* GND1 abstracted; no device emitted
R1 2 3 10k
R2 4 3 10k
R3 5 6 10k
R4 7 6 10k
R5 3 8 10k
R6 6 0 10k
* TP1 abstracted; no device emitted
* TP2 abstracted; no device emitted
* TP3 abstracted; no device emitted
* TP4 abstracted; no device emitted
* TP5 abstracted; no device emitted
* TP6 abstracted; no device emitted
* U1 abstracted; no device emitted
.options abstol=1e-12
.options method=gear
.options reltol=1e-3
.options vntol=1e-6
.op
* added by the bench: the drive, and the parts fang abstracted
VDRIVE_e1 2 0 DC 0
VDRIVE_e2 4 0 DC 1
VDRIVE_e3 5 0 DC 0
VDRIVE_e4 7 0 DC 0
XU1 6 3 8 HB_OPAMP A=1e+06 GBW=1e+07 VOH=13.5 VOL=-13.5 VOS=0
.subckt HB_OPAMP inp inn out A=1e6 GBW=1e7 VOH=13.5 VOL=-13.5 VOS=0
VOS inp x DC {VOS}
RIN x inn 1e12
GM 0 n1 x inn 1e-3
R1 n1 0 {A*1e3}
C1 n1 0 {1e-3/(6.283185307179586*GBW)}
DH n1 h HB_CLAMP
VH h 0 DC {VOH}
DL l n1 HB_CLAMP
VL l 0 DC {VOL}
EO out 0 n1 0 1
.model HB_CLAMP D(IS=1e-15 N=0.01)
.ends HB_OPAMP
.control
run
let gain_e2 = v(8) / v(4)
print gain_e2
.endc
.end
